simulator lang=spectre

// TSMC40 standard-Vt gm/ID characterization.
// PDK CDF: 1.1 V nch/pch, default drawn L=40 nm.
include "/PDKS/TSMC40nm/models/spectre/toplevel.scs" section=top_tt

parameters VSWEEP=0

VGN (gn 0) vsource dc=VSWEEP
VGP (gp 0) vsource dc=-VSWEEP

VDN005 (dn005 0) vsource dc=0.05
VDN055 (dn055 0) vsource dc=0.55
VDN110 (dn110 0) vsource dc=1.10
VDP005 (dp005 0) vsource dc=-0.05
VDP055 (dp055 0) vsource dc=-0.55
VDP110 (dp110 0) vsource dc=-1.10

MN005 (dn005 gn 0 0) nch w=1u l=40n
MN055 (dn055 gn 0 0) nch w=1u l=40n
MN110 (dn110 gn 0 0) nch w=1u l=40n
MP005 (dp005 gp 0 0) pch w=1u l=40n
MP055 (dp055 gp 0 0) pch w=1u l=40n
MP110 (dp110 gp 0 0) pch w=1u l=40n

save MN005:ids MN005:gm MN005:gds MN005:cgg MN005:cgd MN005:cgs MN005:vth MN005:vdsat MN005:gmoverid MN005:self_gain
save MN055:ids MN055:gm MN055:gds MN055:cgg MN055:cgd MN055:cgs MN055:vth MN055:vdsat MN055:gmoverid MN055:self_gain
save MN110:ids MN110:gm MN110:gds MN110:cgg MN110:cgd MN110:cgs MN110:vth MN110:vdsat MN110:gmoverid MN110:self_gain
save MP005:ids MP005:gm MP005:gds MP005:cgg MP005:cgd MP005:cgs MP005:vth MP005:vdsat MP005:gmoverid MP005:self_gain
save MP055:ids MP055:gm MP055:gds MP055:cgg MP055:cgd MP055:cgs MP055:vth MP055:vdsat MP055:gmoverid MP055:self_gain
save MP110:ids MP110:gm MP110:gds MP110:cgg MP110:cgd MP110:cgs MP110:vth MP110:vdsat MP110:gmoverid MP110:self_gain

dc1 dc param=VSWEEP start=0 stop=1.1 step=0.005
